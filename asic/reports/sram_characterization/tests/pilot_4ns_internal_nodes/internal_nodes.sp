* Delay stimulus for period of 4.0n load=27.56fF slew=0.04ns

* TT process corner
.lib "/home/luxyxp/.ciel/ciel/sky130/versions/8afc8346a57fe1ab7934ba5a6056ea8b43078e71/sky130A/libs.tech/ngspice/sky130.lib.spice" tt
.include "/tmp/openram_luxyxp_152448_temp/trimmed.sp"

* Global Power Supplies
Vvdd vdd 0 1.8

*Nodes gnd and 0 are the same global ground node in ngspice/hspice/xa. Otherwise, this source may be needed.
*Vgnd gnd 0 0.0

* Instantiation of the SRAM
Xsky130_sram_1kbyte_1rw1r_32x256_8 din0_31 din0_30 din0_29 din0_28 din0_27 din0_26 din0_25 din0_24 din0_23 din0_22 din0_21 din0_20 din0_19 din0_18 din0_17 din0_16 din0_15 din0_14 din0_13 din0_12 din0_11 din0_10 din0_9 din0_8 din0_7 din0_6 din0_5 din0_4 din0_3 din0_2 din0_1 din0_0 a0_7 a0_6 a0_5 a0_4 a0_3 a0_2 a0_1 a0_0 a1_7 a1_6 a1_5 a1_4 a1_3 a1_2 a1_1 a1_0 CSB0 CSB1 WEB0 clk0 clk1 WMASK0_3 WMASK0_2 WMASK0_1 WMASK0_0 dout0_31 dout0_30 dout0_29 dout0_28 dout0_27 dout0_26 dout0_25 dout0_24 dout0_23 dout0_22 dout0_21 dout0_20 dout0_19 dout0_18 dout0_17 dout0_16 dout0_15 dout0_14 dout0_13 dout0_12 dout0_11 dout0_10 dout0_9 dout0_8 dout0_7 dout0_6 dout0_5 dout0_4 dout0_3 dout0_2 dout0_1 dout0_0 dout1_31 dout1_30 dout1_29 dout1_28 dout1_27 dout1_26 dout1_25 dout1_24 dout1_23 dout1_22 dout1_21 dout1_20 dout1_19 dout1_18 dout1_17 dout1_16 dout1_15 dout1_14 dout1_13 dout1_12 dout1_11 dout1_10 dout1_9 dout1_8 dout1_7 dout1_6 dout1_5 dout1_4 dout1_3 dout1_2 dout1_1 dout1_0 vdd gnd sky130_sram_1kbyte_1rw1r_32x256_8

* SRAM output loads
CD00 dout0_0 0 27.56f
CD01 dout0_1 0 27.56f
CD02 dout0_2 0 27.56f
CD03 dout0_3 0 27.56f
CD04 dout0_4 0 27.56f
CD05 dout0_5 0 27.56f
CD06 dout0_6 0 27.56f
CD07 dout0_7 0 27.56f
CD08 dout0_8 0 27.56f
CD09 dout0_9 0 27.56f
CD010 dout0_10 0 27.56f
CD011 dout0_11 0 27.56f
CD012 dout0_12 0 27.56f
CD013 dout0_13 0 27.56f
CD014 dout0_14 0 27.56f
CD015 dout0_15 0 27.56f
CD016 dout0_16 0 27.56f
CD017 dout0_17 0 27.56f
CD018 dout0_18 0 27.56f
CD019 dout0_19 0 27.56f
CD020 dout0_20 0 27.56f
CD021 dout0_21 0 27.56f
CD022 dout0_22 0 27.56f
CD023 dout0_23 0 27.56f
CD024 dout0_24 0 27.56f
CD025 dout0_25 0 27.56f
CD026 dout0_26 0 27.56f
CD027 dout0_27 0 27.56f
CD028 dout0_28 0 27.56f
CD029 dout0_29 0 27.56f
CD030 dout0_30 0 27.56f
CD031 dout0_31 0 27.56f
CD10 dout1_0 0 27.56f
CD11 dout1_1 0 27.56f
CD12 dout1_2 0 27.56f
CD13 dout1_3 0 27.56f
CD14 dout1_4 0 27.56f
CD15 dout1_5 0 27.56f
CD16 dout1_6 0 27.56f
CD17 dout1_7 0 27.56f
CD18 dout1_8 0 27.56f
CD19 dout1_9 0 27.56f
CD110 dout1_10 0 27.56f
CD111 dout1_11 0 27.56f
CD112 dout1_12 0 27.56f
CD113 dout1_13 0 27.56f
CD114 dout1_14 0 27.56f
CD115 dout1_15 0 27.56f
CD116 dout1_16 0 27.56f
CD117 dout1_17 0 27.56f
CD118 dout1_18 0 27.56f
CD119 dout1_19 0 27.56f
CD120 dout1_20 0 27.56f
CD121 dout1_21 0 27.56f
CD122 dout1_22 0 27.56f
CD123 dout1_23 0 27.56f
CD124 dout1_24 0 27.56f
CD125 dout1_25 0 27.56f
CD126 dout1_26 0 27.56f
CD127 dout1_27 0 27.56f
CD128 dout1_28 0 27.56f
CD129 dout1_29 0 27.56f
CD130 dout1_30 0 27.56f
CD131 dout1_31 0 27.56f

* Generation of data and address signals
* (time, data): [(0, 0), (4.0, 1), (8.0, 0), (12.0, 0), (16.0, 0), (20.0, 0), (24.0, 0), (28.0, 0), (32.0, 1), (36.0, 1), (40.0, 0), (44.0, 0), (48.0, 0), (52.0, 0), (56.0, 0)]
Vdin0_0  din0_0  0 PWL (0n 0.0v 3.78n 0.0v 3.82n 1.8v 7.78n 1.8v 7.819999999999999n 0.0v 11.780000000000001n 0.0v 11.82n 0.0v 15.780000000000001n 0.0v 15.82n 0.0v 19.78n 0.0v 19.82n 0.0v 23.78n 0.0v 23.82n 0.0v 27.78n 0.0v 27.82n 0.0v 31.78n 0.0v 31.82n 1.8v 35.779999999999994n 1.8v 35.82n 1.8v 39.779999999999994n 1.8v 39.82n 0.0v 43.779999999999994n 0.0v 43.82n 0.0v 47.779999999999994n 0.0v 47.82n 0.0v 51.779999999999994n 0.0v 51.82n 0.0v 55.779999999999994n 0.0v 55.82n 0.0v )
* (time, data): [(0, 0), (4.0, 1), (8.0, 0), (12.0, 0), (16.0, 0), (20.0, 0), (24.0, 0), (28.0, 0), (32.0, 1), (36.0, 1), (40.0, 0), (44.0, 0), (48.0, 0), (52.0, 0), (56.0, 0)]
Vdin0_1  din0_1  0 PWL (0n 0.0v 3.78n 0.0v 3.82n 1.8v 7.78n 1.8v 7.819999999999999n 0.0v 11.780000000000001n 0.0v 11.82n 0.0v 15.780000000000001n 0.0v 15.82n 0.0v 19.78n 0.0v 19.82n 0.0v 23.78n 0.0v 23.82n 0.0v 27.78n 0.0v 27.82n 0.0v 31.78n 0.0v 31.82n 1.8v 35.779999999999994n 1.8v 35.82n 1.8v 39.779999999999994n 1.8v 39.82n 0.0v 43.779999999999994n 0.0v 43.82n 0.0v 47.779999999999994n 0.0v 47.82n 0.0v 51.779999999999994n 0.0v 51.82n 0.0v 55.779999999999994n 0.0v 55.82n 0.0v )
* (time, data): [(0, 0), (4.0, 1), (8.0, 0), (12.0, 0), (16.0, 0), (20.0, 0), (24.0, 0), (28.0, 0), (32.0, 1), (36.0, 1), (40.0, 0), (44.0, 0), (48.0, 0), (52.0, 0), (56.0, 0)]
Vdin0_2  din0_2  0 PWL (0n 0.0v 3.78n 0.0v 3.82n 1.8v 7.78n 1.8v 7.819999999999999n 0.0v 11.780000000000001n 0.0v 11.82n 0.0v 15.780000000000001n 0.0v 15.82n 0.0v 19.78n 0.0v 19.82n 0.0v 23.78n 0.0v 23.82n 0.0v 27.78n 0.0v 27.82n 0.0v 31.78n 0.0v 31.82n 1.8v 35.779999999999994n 1.8v 35.82n 1.8v 39.779999999999994n 1.8v 39.82n 0.0v 43.779999999999994n 0.0v 43.82n 0.0v 47.779999999999994n 0.0v 47.82n 0.0v 51.779999999999994n 0.0v 51.82n 0.0v 55.779999999999994n 0.0v 55.82n 0.0v )
* (time, data): [(0, 0), (4.0, 1), (8.0, 0), (12.0, 0), (16.0, 0), (20.0, 0), (24.0, 0), (28.0, 0), (32.0, 1), (36.0, 1), (40.0, 0), (44.0, 0), (48.0, 0), (52.0, 0), (56.0, 0)]
Vdin0_3  din0_3  0 PWL (0n 0.0v 3.78n 0.0v 3.82n 1.8v 7.78n 1.8v 7.819999999999999n 0.0v 11.780000000000001n 0.0v 11.82n 0.0v 15.780000000000001n 0.0v 15.82n 0.0v 19.78n 0.0v 19.82n 0.0v 23.78n 0.0v 23.82n 0.0v 27.78n 0.0v 27.82n 0.0v 31.78n 0.0v 31.82n 1.8v 35.779999999999994n 1.8v 35.82n 1.8v 39.779999999999994n 1.8v 39.82n 0.0v 43.779999999999994n 0.0v 43.82n 0.0v 47.779999999999994n 0.0v 47.82n 0.0v 51.779999999999994n 0.0v 51.82n 0.0v 55.779999999999994n 0.0v 55.82n 0.0v )
* (time, data): [(0, 0), (4.0, 1), (8.0, 0), (12.0, 0), (16.0, 0), (20.0, 0), (24.0, 0), (28.0, 0), (32.0, 1), (36.0, 1), (40.0, 0), (44.0, 0), (48.0, 0), (52.0, 0), (56.0, 0)]
Vdin0_4  din0_4  0 PWL (0n 0.0v 3.78n 0.0v 3.82n 1.8v 7.78n 1.8v 7.819999999999999n 0.0v 11.780000000000001n 0.0v 11.82n 0.0v 15.780000000000001n 0.0v 15.82n 0.0v 19.78n 0.0v 19.82n 0.0v 23.78n 0.0v 23.82n 0.0v 27.78n 0.0v 27.82n 0.0v 31.78n 0.0v 31.82n 1.8v 35.779999999999994n 1.8v 35.82n 1.8v 39.779999999999994n 1.8v 39.82n 0.0v 43.779999999999994n 0.0v 43.82n 0.0v 47.779999999999994n 0.0v 47.82n 0.0v 51.779999999999994n 0.0v 51.82n 0.0v 55.779999999999994n 0.0v 55.82n 0.0v )
* (time, data): [(0, 0), (4.0, 1), (8.0, 0), (12.0, 0), (16.0, 0), (20.0, 0), (24.0, 0), (28.0, 0), (32.0, 1), (36.0, 1), (40.0, 0), (44.0, 0), (48.0, 0), (52.0, 0), (56.0, 0)]
Vdin0_5  din0_5  0 PWL (0n 0.0v 3.78n 0.0v 3.82n 1.8v 7.78n 1.8v 7.819999999999999n 0.0v 11.780000000000001n 0.0v 11.82n 0.0v 15.780000000000001n 0.0v 15.82n 0.0v 19.78n 0.0v 19.82n 0.0v 23.78n 0.0v 23.82n 0.0v 27.78n 0.0v 27.82n 0.0v 31.78n 0.0v 31.82n 1.8v 35.779999999999994n 1.8v 35.82n 1.8v 39.779999999999994n 1.8v 39.82n 0.0v 43.779999999999994n 0.0v 43.82n 0.0v 47.779999999999994n 0.0v 47.82n 0.0v 51.779999999999994n 0.0v 51.82n 0.0v 55.779999999999994n 0.0v 55.82n 0.0v )
* (time, data): [(0, 0), (4.0, 1), (8.0, 0), (12.0, 0), (16.0, 0), (20.0, 0), (24.0, 0), (28.0, 0), (32.0, 1), (36.0, 1), (40.0, 0), (44.0, 0), (48.0, 0), (52.0, 0), (56.0, 0)]
Vdin0_6  din0_6  0 PWL (0n 0.0v 3.78n 0.0v 3.82n 1.8v 7.78n 1.8v 7.819999999999999n 0.0v 11.780000000000001n 0.0v 11.82n 0.0v 15.780000000000001n 0.0v 15.82n 0.0v 19.78n 0.0v 19.82n 0.0v 23.78n 0.0v 23.82n 0.0v 27.78n 0.0v 27.82n 0.0v 31.78n 0.0v 31.82n 1.8v 35.779999999999994n 1.8v 35.82n 1.8v 39.779999999999994n 1.8v 39.82n 0.0v 43.779999999999994n 0.0v 43.82n 0.0v 47.779999999999994n 0.0v 47.82n 0.0v 51.779999999999994n 0.0v 51.82n 0.0v 55.779999999999994n 0.0v 55.82n 0.0v )
* (time, data): [(0, 0), (4.0, 1), (8.0, 0), (12.0, 0), (16.0, 0), (20.0, 0), (24.0, 0), (28.0, 0), (32.0, 1), (36.0, 1), (40.0, 0), (44.0, 0), (48.0, 0), (52.0, 0), (56.0, 0)]
Vdin0_7  din0_7  0 PWL (0n 0.0v 3.78n 0.0v 3.82n 1.8v 7.78n 1.8v 7.819999999999999n 0.0v 11.780000000000001n 0.0v 11.82n 0.0v 15.780000000000001n 0.0v 15.82n 0.0v 19.78n 0.0v 19.82n 0.0v 23.78n 0.0v 23.82n 0.0v 27.78n 0.0v 27.82n 0.0v 31.78n 0.0v 31.82n 1.8v 35.779999999999994n 1.8v 35.82n 1.8v 39.779999999999994n 1.8v 39.82n 0.0v 43.779999999999994n 0.0v 43.82n 0.0v 47.779999999999994n 0.0v 47.82n 0.0v 51.779999999999994n 0.0v 51.82n 0.0v 55.779999999999994n 0.0v 55.82n 0.0v )
* (time, data): [(0, 0), (4.0, 1), (8.0, 0), (12.0, 0), (16.0, 0), (20.0, 0), (24.0, 0), (28.0, 0), (32.0, 1), (36.0, 1), (40.0, 0), (44.0, 0), (48.0, 0), (52.0, 0), (56.0, 0)]
Vdin0_8  din0_8  0 PWL (0n 0.0v 3.78n 0.0v 3.82n 1.8v 7.78n 1.8v 7.819999999999999n 0.0v 11.780000000000001n 0.0v 11.82n 0.0v 15.780000000000001n 0.0v 15.82n 0.0v 19.78n 0.0v 19.82n 0.0v 23.78n 0.0v 23.82n 0.0v 27.78n 0.0v 27.82n 0.0v 31.78n 0.0v 31.82n 1.8v 35.779999999999994n 1.8v 35.82n 1.8v 39.779999999999994n 1.8v 39.82n 0.0v 43.779999999999994n 0.0v 43.82n 0.0v 47.779999999999994n 0.0v 47.82n 0.0v 51.779999999999994n 0.0v 51.82n 0.0v 55.779999999999994n 0.0v 55.82n 0.0v )
* (time, data): [(0, 0), (4.0, 1), (8.0, 0), (12.0, 0), (16.0, 0), (20.0, 0), (24.0, 0), (28.0, 0), (32.0, 1), (36.0, 1), (40.0, 0), (44.0, 0), (48.0, 0), (52.0, 0), (56.0, 0)]
Vdin0_9  din0_9  0 PWL (0n 0.0v 3.78n 0.0v 3.82n 1.8v 7.78n 1.8v 7.819999999999999n 0.0v 11.780000000000001n 0.0v 11.82n 0.0v 15.780000000000001n 0.0v 15.82n 0.0v 19.78n 0.0v 19.82n 0.0v 23.78n 0.0v 23.82n 0.0v 27.78n 0.0v 27.82n 0.0v 31.78n 0.0v 31.82n 1.8v 35.779999999999994n 1.8v 35.82n 1.8v 39.779999999999994n 1.8v 39.82n 0.0v 43.779999999999994n 0.0v 43.82n 0.0v 47.779999999999994n 0.0v 47.82n 0.0v 51.779999999999994n 0.0v 51.82n 0.0v 55.779999999999994n 0.0v 55.82n 0.0v )
* (time, data): [(0, 0), (4.0, 1), (8.0, 0), (12.0, 0), (16.0, 0), (20.0, 0), (24.0, 0), (28.0, 0), (32.0, 1), (36.0, 1), (40.0, 0), (44.0, 0), (48.0, 0), (52.0, 0), (56.0, 0)]
Vdin0_10  din0_10  0 PWL (0n 0.0v 3.78n 0.0v 3.82n 1.8v 7.78n 1.8v 7.819999999999999n 0.0v 11.780000000000001n 0.0v 11.82n 0.0v 15.780000000000001n 0.0v 15.82n 0.0v 19.78n 0.0v 19.82n 0.0v 23.78n 0.0v 23.82n 0.0v 27.78n 0.0v 27.82n 0.0v 31.78n 0.0v 31.82n 1.8v 35.779999999999994n 1.8v 35.82n 1.8v 39.779999999999994n 1.8v 39.82n 0.0v 43.779999999999994n 0.0v 43.82n 0.0v 47.779999999999994n 0.0v 47.82n 0.0v 51.779999999999994n 0.0v 51.82n 0.0v 55.779999999999994n 0.0v 55.82n 0.0v )
* (time, data): [(0, 0), (4.0, 1), (8.0, 0), (12.0, 0), (16.0, 0), (20.0, 0), (24.0, 0), (28.0, 0), (32.0, 1), (36.0, 1), (40.0, 0), (44.0, 0), (48.0, 0), (52.0, 0), (56.0, 0)]
Vdin0_11  din0_11  0 PWL (0n 0.0v 3.78n 0.0v 3.82n 1.8v 7.78n 1.8v 7.819999999999999n 0.0v 11.780000000000001n 0.0v 11.82n 0.0v 15.780000000000001n 0.0v 15.82n 0.0v 19.78n 0.0v 19.82n 0.0v 23.78n 0.0v 23.82n 0.0v 27.78n 0.0v 27.82n 0.0v 31.78n 0.0v 31.82n 1.8v 35.779999999999994n 1.8v 35.82n 1.8v 39.779999999999994n 1.8v 39.82n 0.0v 43.779999999999994n 0.0v 43.82n 0.0v 47.779999999999994n 0.0v 47.82n 0.0v 51.779999999999994n 0.0v 51.82n 0.0v 55.779999999999994n 0.0v 55.82n 0.0v )
* (time, data): [(0, 0), (4.0, 1), (8.0, 0), (12.0, 0), (16.0, 0), (20.0, 0), (24.0, 0), (28.0, 0), (32.0, 1), (36.0, 1), (40.0, 0), (44.0, 0), (48.0, 0), (52.0, 0), (56.0, 0)]
Vdin0_12  din0_12  0 PWL (0n 0.0v 3.78n 0.0v 3.82n 1.8v 7.78n 1.8v 7.819999999999999n 0.0v 11.780000000000001n 0.0v 11.82n 0.0v 15.780000000000001n 0.0v 15.82n 0.0v 19.78n 0.0v 19.82n 0.0v 23.78n 0.0v 23.82n 0.0v 27.78n 0.0v 27.82n 0.0v 31.78n 0.0v 31.82n 1.8v 35.779999999999994n 1.8v 35.82n 1.8v 39.779999999999994n 1.8v 39.82n 0.0v 43.779999999999994n 0.0v 43.82n 0.0v 47.779999999999994n 0.0v 47.82n 0.0v 51.779999999999994n 0.0v 51.82n 0.0v 55.779999999999994n 0.0v 55.82n 0.0v )
* (time, data): [(0, 0), (4.0, 1), (8.0, 0), (12.0, 0), (16.0, 0), (20.0, 0), (24.0, 0), (28.0, 0), (32.0, 1), (36.0, 1), (40.0, 0), (44.0, 0), (48.0, 0), (52.0, 0), (56.0, 0)]
Vdin0_13  din0_13  0 PWL (0n 0.0v 3.78n 0.0v 3.82n 1.8v 7.78n 1.8v 7.819999999999999n 0.0v 11.780000000000001n 0.0v 11.82n 0.0v 15.780000000000001n 0.0v 15.82n 0.0v 19.78n 0.0v 19.82n 0.0v 23.78n 0.0v 23.82n 0.0v 27.78n 0.0v 27.82n 0.0v 31.78n 0.0v 31.82n 1.8v 35.779999999999994n 1.8v 35.82n 1.8v 39.779999999999994n 1.8v 39.82n 0.0v 43.779999999999994n 0.0v 43.82n 0.0v 47.779999999999994n 0.0v 47.82n 0.0v 51.779999999999994n 0.0v 51.82n 0.0v 55.779999999999994n 0.0v 55.82n 0.0v )
* (time, data): [(0, 0), (4.0, 1), (8.0, 0), (12.0, 0), (16.0, 0), (20.0, 0), (24.0, 0), (28.0, 0), (32.0, 1), (36.0, 1), (40.0, 0), (44.0, 0), (48.0, 0), (52.0, 0), (56.0, 0)]
Vdin0_14  din0_14  0 PWL (0n 0.0v 3.78n 0.0v 3.82n 1.8v 7.78n 1.8v 7.819999999999999n 0.0v 11.780000000000001n 0.0v 11.82n 0.0v 15.780000000000001n 0.0v 15.82n 0.0v 19.78n 0.0v 19.82n 0.0v 23.78n 0.0v 23.82n 0.0v 27.78n 0.0v 27.82n 0.0v 31.78n 0.0v 31.82n 1.8v 35.779999999999994n 1.8v 35.82n 1.8v 39.779999999999994n 1.8v 39.82n 0.0v 43.779999999999994n 0.0v 43.82n 0.0v 47.779999999999994n 0.0v 47.82n 0.0v 51.779999999999994n 0.0v 51.82n 0.0v 55.779999999999994n 0.0v 55.82n 0.0v )
* (time, data): [(0, 0), (4.0, 1), (8.0, 0), (12.0, 0), (16.0, 0), (20.0, 0), (24.0, 0), (28.0, 0), (32.0, 1), (36.0, 1), (40.0, 0), (44.0, 0), (48.0, 0), (52.0, 0), (56.0, 0)]
Vdin0_15  din0_15  0 PWL (0n 0.0v 3.78n 0.0v 3.82n 1.8v 7.78n 1.8v 7.819999999999999n 0.0v 11.780000000000001n 0.0v 11.82n 0.0v 15.780000000000001n 0.0v 15.82n 0.0v 19.78n 0.0v 19.82n 0.0v 23.78n 0.0v 23.82n 0.0v 27.78n 0.0v 27.82n 0.0v 31.78n 0.0v 31.82n 1.8v 35.779999999999994n 1.8v 35.82n 1.8v 39.779999999999994n 1.8v 39.82n 0.0v 43.779999999999994n 0.0v 43.82n 0.0v 47.779999999999994n 0.0v 47.82n 0.0v 51.779999999999994n 0.0v 51.82n 0.0v 55.779999999999994n 0.0v 55.82n 0.0v )
* (time, data): [(0, 0), (4.0, 1), (8.0, 0), (12.0, 0), (16.0, 0), (20.0, 0), (24.0, 0), (28.0, 0), (32.0, 1), (36.0, 1), (40.0, 0), (44.0, 0), (48.0, 0), (52.0, 0), (56.0, 0)]
Vdin0_16  din0_16  0 PWL (0n 0.0v 3.78n 0.0v 3.82n 1.8v 7.78n 1.8v 7.819999999999999n 0.0v 11.780000000000001n 0.0v 11.82n 0.0v 15.780000000000001n 0.0v 15.82n 0.0v 19.78n 0.0v 19.82n 0.0v 23.78n 0.0v 23.82n 0.0v 27.78n 0.0v 27.82n 0.0v 31.78n 0.0v 31.82n 1.8v 35.779999999999994n 1.8v 35.82n 1.8v 39.779999999999994n 1.8v 39.82n 0.0v 43.779999999999994n 0.0v 43.82n 0.0v 47.779999999999994n 0.0v 47.82n 0.0v 51.779999999999994n 0.0v 51.82n 0.0v 55.779999999999994n 0.0v 55.82n 0.0v )
* (time, data): [(0, 0), (4.0, 1), (8.0, 0), (12.0, 0), (16.0, 0), (20.0, 0), (24.0, 0), (28.0, 0), (32.0, 1), (36.0, 1), (40.0, 0), (44.0, 0), (48.0, 0), (52.0, 0), (56.0, 0)]
Vdin0_17  din0_17  0 PWL (0n 0.0v 3.78n 0.0v 3.82n 1.8v 7.78n 1.8v 7.819999999999999n 0.0v 11.780000000000001n 0.0v 11.82n 0.0v 15.780000000000001n 0.0v 15.82n 0.0v 19.78n 0.0v 19.82n 0.0v 23.78n 0.0v 23.82n 0.0v 27.78n 0.0v 27.82n 0.0v 31.78n 0.0v 31.82n 1.8v 35.779999999999994n 1.8v 35.82n 1.8v 39.779999999999994n 1.8v 39.82n 0.0v 43.779999999999994n 0.0v 43.82n 0.0v 47.779999999999994n 0.0v 47.82n 0.0v 51.779999999999994n 0.0v 51.82n 0.0v 55.779999999999994n 0.0v 55.82n 0.0v )
* (time, data): [(0, 0), (4.0, 1), (8.0, 0), (12.0, 0), (16.0, 0), (20.0, 0), (24.0, 0), (28.0, 0), (32.0, 1), (36.0, 1), (40.0, 0), (44.0, 0), (48.0, 0), (52.0, 0), (56.0, 0)]
Vdin0_18  din0_18  0 PWL (0n 0.0v 3.78n 0.0v 3.82n 1.8v 7.78n 1.8v 7.819999999999999n 0.0v 11.780000000000001n 0.0v 11.82n 0.0v 15.780000000000001n 0.0v 15.82n 0.0v 19.78n 0.0v 19.82n 0.0v 23.78n 0.0v 23.82n 0.0v 27.78n 0.0v 27.82n 0.0v 31.78n 0.0v 31.82n 1.8v 35.779999999999994n 1.8v 35.82n 1.8v 39.779999999999994n 1.8v 39.82n 0.0v 43.779999999999994n 0.0v 43.82n 0.0v 47.779999999999994n 0.0v 47.82n 0.0v 51.779999999999994n 0.0v 51.82n 0.0v 55.779999999999994n 0.0v 55.82n 0.0v )
* (time, data): [(0, 0), (4.0, 1), (8.0, 0), (12.0, 0), (16.0, 0), (20.0, 0), (24.0, 0), (28.0, 0), (32.0, 1), (36.0, 1), (40.0, 0), (44.0, 0), (48.0, 0), (52.0, 0), (56.0, 0)]
Vdin0_19  din0_19  0 PWL (0n 0.0v 3.78n 0.0v 3.82n 1.8v 7.78n 1.8v 7.819999999999999n 0.0v 11.780000000000001n 0.0v 11.82n 0.0v 15.780000000000001n 0.0v 15.82n 0.0v 19.78n 0.0v 19.82n 0.0v 23.78n 0.0v 23.82n 0.0v 27.78n 0.0v 27.82n 0.0v 31.78n 0.0v 31.82n 1.8v 35.779999999999994n 1.8v 35.82n 1.8v 39.779999999999994n 1.8v 39.82n 0.0v 43.779999999999994n 0.0v 43.82n 0.0v 47.779999999999994n 0.0v 47.82n 0.0v 51.779999999999994n 0.0v 51.82n 0.0v 55.779999999999994n 0.0v 55.82n 0.0v )
* (time, data): [(0, 0), (4.0, 1), (8.0, 0), (12.0, 0), (16.0, 0), (20.0, 0), (24.0, 0), (28.0, 0), (32.0, 1), (36.0, 1), (40.0, 0), (44.0, 0), (48.0, 0), (52.0, 0), (56.0, 0)]
Vdin0_20  din0_20  0 PWL (0n 0.0v 3.78n 0.0v 3.82n 1.8v 7.78n 1.8v 7.819999999999999n 0.0v 11.780000000000001n 0.0v 11.82n 0.0v 15.780000000000001n 0.0v 15.82n 0.0v 19.78n 0.0v 19.82n 0.0v 23.78n 0.0v 23.82n 0.0v 27.78n 0.0v 27.82n 0.0v 31.78n 0.0v 31.82n 1.8v 35.779999999999994n 1.8v 35.82n 1.8v 39.779999999999994n 1.8v 39.82n 0.0v 43.779999999999994n 0.0v 43.82n 0.0v 47.779999999999994n 0.0v 47.82n 0.0v 51.779999999999994n 0.0v 51.82n 0.0v 55.779999999999994n 0.0v 55.82n 0.0v )
* (time, data): [(0, 0), (4.0, 1), (8.0, 0), (12.0, 0), (16.0, 0), (20.0, 0), (24.0, 0), (28.0, 0), (32.0, 1), (36.0, 1), (40.0, 0), (44.0, 0), (48.0, 0), (52.0, 0), (56.0, 0)]
Vdin0_21  din0_21  0 PWL (0n 0.0v 3.78n 0.0v 3.82n 1.8v 7.78n 1.8v 7.819999999999999n 0.0v 11.780000000000001n 0.0v 11.82n 0.0v 15.780000000000001n 0.0v 15.82n 0.0v 19.78n 0.0v 19.82n 0.0v 23.78n 0.0v 23.82n 0.0v 27.78n 0.0v 27.82n 0.0v 31.78n 0.0v 31.82n 1.8v 35.779999999999994n 1.8v 35.82n 1.8v 39.779999999999994n 1.8v 39.82n 0.0v 43.779999999999994n 0.0v 43.82n 0.0v 47.779999999999994n 0.0v 47.82n 0.0v 51.779999999999994n 0.0v 51.82n 0.0v 55.779999999999994n 0.0v 55.82n 0.0v )
* (time, data): [(0, 0), (4.0, 1), (8.0, 0), (12.0, 0), (16.0, 0), (20.0, 0), (24.0, 0), (28.0, 0), (32.0, 1), (36.0, 1), (40.0, 0), (44.0, 0), (48.0, 0), (52.0, 0), (56.0, 0)]
Vdin0_22  din0_22  0 PWL (0n 0.0v 3.78n 0.0v 3.82n 1.8v 7.78n 1.8v 7.819999999999999n 0.0v 11.780000000000001n 0.0v 11.82n 0.0v 15.780000000000001n 0.0v 15.82n 0.0v 19.78n 0.0v 19.82n 0.0v 23.78n 0.0v 23.82n 0.0v 27.78n 0.0v 27.82n 0.0v 31.78n 0.0v 31.82n 1.8v 35.779999999999994n 1.8v 35.82n 1.8v 39.779999999999994n 1.8v 39.82n 0.0v 43.779999999999994n 0.0v 43.82n 0.0v 47.779999999999994n 0.0v 47.82n 0.0v 51.779999999999994n 0.0v 51.82n 0.0v 55.779999999999994n 0.0v 55.82n 0.0v )
* (time, data): [(0, 0), (4.0, 1), (8.0, 0), (12.0, 0), (16.0, 0), (20.0, 0), (24.0, 0), (28.0, 0), (32.0, 1), (36.0, 1), (40.0, 0), (44.0, 0), (48.0, 0), (52.0, 0), (56.0, 0)]
Vdin0_23  din0_23  0 PWL (0n 0.0v 3.78n 0.0v 3.82n 1.8v 7.78n 1.8v 7.819999999999999n 0.0v 11.780000000000001n 0.0v 11.82n 0.0v 15.780000000000001n 0.0v 15.82n 0.0v 19.78n 0.0v 19.82n 0.0v 23.78n 0.0v 23.82n 0.0v 27.78n 0.0v 27.82n 0.0v 31.78n 0.0v 31.82n 1.8v 35.779999999999994n 1.8v 35.82n 1.8v 39.779999999999994n 1.8v 39.82n 0.0v 43.779999999999994n 0.0v 43.82n 0.0v 47.779999999999994n 0.0v 47.82n 0.0v 51.779999999999994n 0.0v 51.82n 0.0v 55.779999999999994n 0.0v 55.82n 0.0v )
* (time, data): [(0, 0), (4.0, 1), (8.0, 0), (12.0, 0), (16.0, 0), (20.0, 0), (24.0, 0), (28.0, 0), (32.0, 1), (36.0, 1), (40.0, 0), (44.0, 0), (48.0, 0), (52.0, 0), (56.0, 0)]
Vdin0_24  din0_24  0 PWL (0n 0.0v 3.78n 0.0v 3.82n 1.8v 7.78n 1.8v 7.819999999999999n 0.0v 11.780000000000001n 0.0v 11.82n 0.0v 15.780000000000001n 0.0v 15.82n 0.0v 19.78n 0.0v 19.82n 0.0v 23.78n 0.0v 23.82n 0.0v 27.78n 0.0v 27.82n 0.0v 31.78n 0.0v 31.82n 1.8v 35.779999999999994n 1.8v 35.82n 1.8v 39.779999999999994n 1.8v 39.82n 0.0v 43.779999999999994n 0.0v 43.82n 0.0v 47.779999999999994n 0.0v 47.82n 0.0v 51.779999999999994n 0.0v 51.82n 0.0v 55.779999999999994n 0.0v 55.82n 0.0v )
* (time, data): [(0, 0), (4.0, 1), (8.0, 0), (12.0, 0), (16.0, 0), (20.0, 0), (24.0, 0), (28.0, 0), (32.0, 1), (36.0, 1), (40.0, 0), (44.0, 0), (48.0, 0), (52.0, 0), (56.0, 0)]
Vdin0_25  din0_25  0 PWL (0n 0.0v 3.78n 0.0v 3.82n 1.8v 7.78n 1.8v 7.819999999999999n 0.0v 11.780000000000001n 0.0v 11.82n 0.0v 15.780000000000001n 0.0v 15.82n 0.0v 19.78n 0.0v 19.82n 0.0v 23.78n 0.0v 23.82n 0.0v 27.78n 0.0v 27.82n 0.0v 31.78n 0.0v 31.82n 1.8v 35.779999999999994n 1.8v 35.82n 1.8v 39.779999999999994n 1.8v 39.82n 0.0v 43.779999999999994n 0.0v 43.82n 0.0v 47.779999999999994n 0.0v 47.82n 0.0v 51.779999999999994n 0.0v 51.82n 0.0v 55.779999999999994n 0.0v 55.82n 0.0v )
* (time, data): [(0, 0), (4.0, 1), (8.0, 0), (12.0, 0), (16.0, 0), (20.0, 0), (24.0, 0), (28.0, 0), (32.0, 1), (36.0, 1), (40.0, 0), (44.0, 0), (48.0, 0), (52.0, 0), (56.0, 0)]
Vdin0_26  din0_26  0 PWL (0n 0.0v 3.78n 0.0v 3.82n 1.8v 7.78n 1.8v 7.819999999999999n 0.0v 11.780000000000001n 0.0v 11.82n 0.0v 15.780000000000001n 0.0v 15.82n 0.0v 19.78n 0.0v 19.82n 0.0v 23.78n 0.0v 23.82n 0.0v 27.78n 0.0v 27.82n 0.0v 31.78n 0.0v 31.82n 1.8v 35.779999999999994n 1.8v 35.82n 1.8v 39.779999999999994n 1.8v 39.82n 0.0v 43.779999999999994n 0.0v 43.82n 0.0v 47.779999999999994n 0.0v 47.82n 0.0v 51.779999999999994n 0.0v 51.82n 0.0v 55.779999999999994n 0.0v 55.82n 0.0v )
* (time, data): [(0, 0), (4.0, 1), (8.0, 0), (12.0, 0), (16.0, 0), (20.0, 0), (24.0, 0), (28.0, 0), (32.0, 1), (36.0, 1), (40.0, 0), (44.0, 0), (48.0, 0), (52.0, 0), (56.0, 0)]
Vdin0_27  din0_27  0 PWL (0n 0.0v 3.78n 0.0v 3.82n 1.8v 7.78n 1.8v 7.819999999999999n 0.0v 11.780000000000001n 0.0v 11.82n 0.0v 15.780000000000001n 0.0v 15.82n 0.0v 19.78n 0.0v 19.82n 0.0v 23.78n 0.0v 23.82n 0.0v 27.78n 0.0v 27.82n 0.0v 31.78n 0.0v 31.82n 1.8v 35.779999999999994n 1.8v 35.82n 1.8v 39.779999999999994n 1.8v 39.82n 0.0v 43.779999999999994n 0.0v 43.82n 0.0v 47.779999999999994n 0.0v 47.82n 0.0v 51.779999999999994n 0.0v 51.82n 0.0v 55.779999999999994n 0.0v 55.82n 0.0v )
* (time, data): [(0, 0), (4.0, 1), (8.0, 0), (12.0, 0), (16.0, 0), (20.0, 0), (24.0, 0), (28.0, 0), (32.0, 1), (36.0, 1), (40.0, 0), (44.0, 0), (48.0, 0), (52.0, 0), (56.0, 0)]
Vdin0_28  din0_28  0 PWL (0n 0.0v 3.78n 0.0v 3.82n 1.8v 7.78n 1.8v 7.819999999999999n 0.0v 11.780000000000001n 0.0v 11.82n 0.0v 15.780000000000001n 0.0v 15.82n 0.0v 19.78n 0.0v 19.82n 0.0v 23.78n 0.0v 23.82n 0.0v 27.78n 0.0v 27.82n 0.0v 31.78n 0.0v 31.82n 1.8v 35.779999999999994n 1.8v 35.82n 1.8v 39.779999999999994n 1.8v 39.82n 0.0v 43.779999999999994n 0.0v 43.82n 0.0v 47.779999999999994n 0.0v 47.82n 0.0v 51.779999999999994n 0.0v 51.82n 0.0v 55.779999999999994n 0.0v 55.82n 0.0v )
* (time, data): [(0, 0), (4.0, 1), (8.0, 0), (12.0, 0), (16.0, 0), (20.0, 0), (24.0, 0), (28.0, 0), (32.0, 1), (36.0, 1), (40.0, 0), (44.0, 0), (48.0, 0), (52.0, 0), (56.0, 0)]
Vdin0_29  din0_29  0 PWL (0n 0.0v 3.78n 0.0v 3.82n 1.8v 7.78n 1.8v 7.819999999999999n 0.0v 11.780000000000001n 0.0v 11.82n 0.0v 15.780000000000001n 0.0v 15.82n 0.0v 19.78n 0.0v 19.82n 0.0v 23.78n 0.0v 23.82n 0.0v 27.78n 0.0v 27.82n 0.0v 31.78n 0.0v 31.82n 1.8v 35.779999999999994n 1.8v 35.82n 1.8v 39.779999999999994n 1.8v 39.82n 0.0v 43.779999999999994n 0.0v 43.82n 0.0v 47.779999999999994n 0.0v 47.82n 0.0v 51.779999999999994n 0.0v 51.82n 0.0v 55.779999999999994n 0.0v 55.82n 0.0v )
* (time, data): [(0, 0), (4.0, 1), (8.0, 0), (12.0, 0), (16.0, 0), (20.0, 0), (24.0, 0), (28.0, 0), (32.0, 1), (36.0, 1), (40.0, 0), (44.0, 0), (48.0, 0), (52.0, 0), (56.0, 0)]
Vdin0_30  din0_30  0 PWL (0n 0.0v 3.78n 0.0v 3.82n 1.8v 7.78n 1.8v 7.819999999999999n 0.0v 11.780000000000001n 0.0v 11.82n 0.0v 15.780000000000001n 0.0v 15.82n 0.0v 19.78n 0.0v 19.82n 0.0v 23.78n 0.0v 23.82n 0.0v 27.78n 0.0v 27.82n 0.0v 31.78n 0.0v 31.82n 1.8v 35.779999999999994n 1.8v 35.82n 1.8v 39.779999999999994n 1.8v 39.82n 0.0v 43.779999999999994n 0.0v 43.82n 0.0v 47.779999999999994n 0.0v 47.82n 0.0v 51.779999999999994n 0.0v 51.82n 0.0v 55.779999999999994n 0.0v 55.82n 0.0v )
* (time, data): [(0, 0), (4.0, 1), (8.0, 0), (12.0, 0), (16.0, 0), (20.0, 0), (24.0, 0), (28.0, 0), (32.0, 1), (36.0, 1), (40.0, 0), (44.0, 0), (48.0, 0), (52.0, 0), (56.0, 0)]
Vdin0_31  din0_31  0 PWL (0n 0.0v 3.78n 0.0v 3.82n 1.8v 7.78n 1.8v 7.819999999999999n 0.0v 11.780000000000001n 0.0v 11.82n 0.0v 15.780000000000001n 0.0v 15.82n 0.0v 19.78n 0.0v 19.82n 0.0v 23.78n 0.0v 23.82n 0.0v 27.78n 0.0v 27.82n 0.0v 31.78n 0.0v 31.82n 1.8v 35.779999999999994n 1.8v 35.82n 1.8v 39.779999999999994n 1.8v 39.82n 0.0v 43.779999999999994n 0.0v 43.82n 0.0v 47.779999999999994n 0.0v 47.82n 0.0v 51.779999999999994n 0.0v 51.82n 0.0v 55.779999999999994n 0.0v 55.82n 0.0v )
* (time, data): [(0, 0), (4.0, 1), (8.0, 1), (12.0, 1), (16.0, 1), (20.0, 1), (24.0, 1), (28.0, 1), (32.0, 1), (36.0, 1), (40.0, 1), (44.0, 1), (48.0, 1), (52.0, 1), (56.0, 1)]
Va0_0 a0_0 0 PWL (0n 0.0v 3.78n 0.0v 3.82n 1.8v 7.78n 1.8v 7.819999999999999n 1.8v 11.780000000000001n 1.8v 11.82n 1.8v 15.780000000000001n 1.8v 15.82n 1.8v 19.78n 1.8v 19.82n 1.8v 23.78n 1.8v 23.82n 1.8v 27.78n 1.8v 27.82n 1.8v 31.78n 1.8v 31.82n 1.8v 35.779999999999994n 1.8v 35.82n 1.8v 39.779999999999994n 1.8v 39.82n 1.8v 43.779999999999994n 1.8v 43.82n 1.8v 47.779999999999994n 1.8v 47.82n 1.8v 51.779999999999994n 1.8v 51.82n 1.8v 55.779999999999994n 1.8v 55.82n 1.8v )
* (time, data): [(0, 0), (4.0, 0), (8.0, 1), (12.0, 1), (16.0, 0), (20.0, 1), (24.0, 1), (28.0, 1), (32.0, 1), (36.0, 1), (40.0, 0), (44.0, 0), (48.0, 0), (52.0, 1), (56.0, 1)]
Va0_1 a0_1 0 PWL (0n 0.0v 3.78n 0.0v 3.82n 0.0v 7.78n 0.0v 7.819999999999999n 1.8v 11.780000000000001n 1.8v 11.82n 1.8v 15.780000000000001n 1.8v 15.82n 0.0v 19.78n 0.0v 19.82n 1.8v 23.78n 1.8v 23.82n 1.8v 27.78n 1.8v 27.82n 1.8v 31.78n 1.8v 31.82n 1.8v 35.779999999999994n 1.8v 35.82n 1.8v 39.779999999999994n 1.8v 39.82n 0.0v 43.779999999999994n 0.0v 43.82n 0.0v 47.779999999999994n 0.0v 47.82n 0.0v 51.779999999999994n 0.0v 51.82n 1.8v 55.779999999999994n 1.8v 55.82n 1.8v )
* (time, data): [(0, 0), (4.0, 0), (8.0, 1), (12.0, 1), (16.0, 0), (20.0, 1), (24.0, 1), (28.0, 1), (32.0, 1), (36.0, 1), (40.0, 0), (44.0, 0), (48.0, 0), (52.0, 1), (56.0, 1)]
Va0_2 a0_2 0 PWL (0n 0.0v 3.78n 0.0v 3.82n 0.0v 7.78n 0.0v 7.819999999999999n 1.8v 11.780000000000001n 1.8v 11.82n 1.8v 15.780000000000001n 1.8v 15.82n 0.0v 19.78n 0.0v 19.82n 1.8v 23.78n 1.8v 23.82n 1.8v 27.78n 1.8v 27.82n 1.8v 31.78n 1.8v 31.82n 1.8v 35.779999999999994n 1.8v 35.82n 1.8v 39.779999999999994n 1.8v 39.82n 0.0v 43.779999999999994n 0.0v 43.82n 0.0v 47.779999999999994n 0.0v 47.82n 0.0v 51.779999999999994n 0.0v 51.82n 1.8v 55.779999999999994n 1.8v 55.82n 1.8v )
* (time, data): [(0, 0), (4.0, 0), (8.0, 1), (12.0, 1), (16.0, 0), (20.0, 1), (24.0, 1), (28.0, 1), (32.0, 1), (36.0, 1), (40.0, 0), (44.0, 0), (48.0, 0), (52.0, 1), (56.0, 1)]
Va0_3 a0_3 0 PWL (0n 0.0v 3.78n 0.0v 3.82n 0.0v 7.78n 0.0v 7.819999999999999n 1.8v 11.780000000000001n 1.8v 11.82n 1.8v 15.780000000000001n 1.8v 15.82n 0.0v 19.78n 0.0v 19.82n 1.8v 23.78n 1.8v 23.82n 1.8v 27.78n 1.8v 27.82n 1.8v 31.78n 1.8v 31.82n 1.8v 35.779999999999994n 1.8v 35.82n 1.8v 39.779999999999994n 1.8v 39.82n 0.0v 43.779999999999994n 0.0v 43.82n 0.0v 47.779999999999994n 0.0v 47.82n 0.0v 51.779999999999994n 0.0v 51.82n 1.8v 55.779999999999994n 1.8v 55.82n 1.8v )
* (time, data): [(0, 0), (4.0, 0), (8.0, 1), (12.0, 1), (16.0, 0), (20.0, 1), (24.0, 1), (28.0, 1), (32.0, 1), (36.0, 1), (40.0, 0), (44.0, 0), (48.0, 0), (52.0, 1), (56.0, 1)]
Va0_4 a0_4 0 PWL (0n 0.0v 3.78n 0.0v 3.82n 0.0v 7.78n 0.0v 7.819999999999999n 1.8v 11.780000000000001n 1.8v 11.82n 1.8v 15.780000000000001n 1.8v 15.82n 0.0v 19.78n 0.0v 19.82n 1.8v 23.78n 1.8v 23.82n 1.8v 27.78n 1.8v 27.82n 1.8v 31.78n 1.8v 31.82n 1.8v 35.779999999999994n 1.8v 35.82n 1.8v 39.779999999999994n 1.8v 39.82n 0.0v 43.779999999999994n 0.0v 43.82n 0.0v 47.779999999999994n 0.0v 47.82n 0.0v 51.779999999999994n 0.0v 51.82n 1.8v 55.779999999999994n 1.8v 55.82n 1.8v )
* (time, data): [(0, 0), (4.0, 0), (8.0, 1), (12.0, 1), (16.0, 0), (20.0, 1), (24.0, 1), (28.0, 1), (32.0, 1), (36.0, 1), (40.0, 0), (44.0, 0), (48.0, 0), (52.0, 1), (56.0, 1)]
Va0_5 a0_5 0 PWL (0n 0.0v 3.78n 0.0v 3.82n 0.0v 7.78n 0.0v 7.819999999999999n 1.8v 11.780000000000001n 1.8v 11.82n 1.8v 15.780000000000001n 1.8v 15.82n 0.0v 19.78n 0.0v 19.82n 1.8v 23.78n 1.8v 23.82n 1.8v 27.78n 1.8v 27.82n 1.8v 31.78n 1.8v 31.82n 1.8v 35.779999999999994n 1.8v 35.82n 1.8v 39.779999999999994n 1.8v 39.82n 0.0v 43.779999999999994n 0.0v 43.82n 0.0v 47.779999999999994n 0.0v 47.82n 0.0v 51.779999999999994n 0.0v 51.82n 1.8v 55.779999999999994n 1.8v 55.82n 1.8v )
* (time, data): [(0, 0), (4.0, 0), (8.0, 1), (12.0, 1), (16.0, 0), (20.0, 1), (24.0, 1), (28.0, 1), (32.0, 1), (36.0, 1), (40.0, 0), (44.0, 0), (48.0, 0), (52.0, 1), (56.0, 1)]
Va0_6 a0_6 0 PWL (0n 0.0v 3.78n 0.0v 3.82n 0.0v 7.78n 0.0v 7.819999999999999n 1.8v 11.780000000000001n 1.8v 11.82n 1.8v 15.780000000000001n 1.8v 15.82n 0.0v 19.78n 0.0v 19.82n 1.8v 23.78n 1.8v 23.82n 1.8v 27.78n 1.8v 27.82n 1.8v 31.78n 1.8v 31.82n 1.8v 35.779999999999994n 1.8v 35.82n 1.8v 39.779999999999994n 1.8v 39.82n 0.0v 43.779999999999994n 0.0v 43.82n 0.0v 47.779999999999994n 0.0v 47.82n 0.0v 51.779999999999994n 0.0v 51.82n 1.8v 55.779999999999994n 1.8v 55.82n 1.8v )
* (time, data): [(0, 0), (4.0, 0), (8.0, 1), (12.0, 1), (16.0, 0), (20.0, 1), (24.0, 1), (28.0, 1), (32.0, 1), (36.0, 1), (40.0, 0), (44.0, 0), (48.0, 0), (52.0, 1), (56.0, 1)]
Va0_7 a0_7 0 PWL (0n 0.0v 3.78n 0.0v 3.82n 0.0v 7.78n 0.0v 7.819999999999999n 1.8v 11.780000000000001n 1.8v 11.82n 1.8v 15.780000000000001n 1.8v 15.82n 0.0v 19.78n 0.0v 19.82n 1.8v 23.78n 1.8v 23.82n 1.8v 27.78n 1.8v 27.82n 1.8v 31.78n 1.8v 31.82n 1.8v 35.779999999999994n 1.8v 35.82n 1.8v 39.779999999999994n 1.8v 39.82n 0.0v 43.779999999999994n 0.0v 43.82n 0.0v 47.779999999999994n 0.0v 47.82n 0.0v 51.779999999999994n 0.0v 51.82n 1.8v 55.779999999999994n 1.8v 55.82n 1.8v )
* (time, data): [(0, 0), (4.0, 0), (8.0, 0), (12.0, 0), (16.0, 0), (20.0, 0), (24.0, 0), (28.0, 0), (32.0, 0), (36.0, 0), (40.0, 0), (44.0, 0), (48.0, 0), (52.0, 0), (56.0, 0)]
Va1_0 a1_0 0 PWL (0n 0.0v 3.78n 0.0v 3.82n 0.0v 7.78n 0.0v 7.819999999999999n 0.0v 11.780000000000001n 0.0v 11.82n 0.0v 15.780000000000001n 0.0v 15.82n 0.0v 19.78n 0.0v 19.82n 0.0v 23.78n 0.0v 23.82n 0.0v 27.78n 0.0v 27.82n 0.0v 31.78n 0.0v 31.82n 0.0v 35.779999999999994n 0.0v 35.82n 0.0v 39.779999999999994n 0.0v 39.82n 0.0v 43.779999999999994n 0.0v 43.82n 0.0v 47.779999999999994n 0.0v 47.82n 0.0v 51.779999999999994n 0.0v 51.82n 0.0v 55.779999999999994n 0.0v 55.82n 0.0v )
* (time, data): [(0, 0), (4.0, 0), (8.0, 0), (12.0, 0), (16.0, 0), (20.0, 0), (24.0, 0), (28.0, 0), (32.0, 0), (36.0, 0), (40.0, 0), (44.0, 0), (48.0, 0), (52.0, 0), (56.0, 0)]
Va1_1 a1_1 0 PWL (0n 0.0v 3.78n 0.0v 3.82n 0.0v 7.78n 0.0v 7.819999999999999n 0.0v 11.780000000000001n 0.0v 11.82n 0.0v 15.780000000000001n 0.0v 15.82n 0.0v 19.78n 0.0v 19.82n 0.0v 23.78n 0.0v 23.82n 0.0v 27.78n 0.0v 27.82n 0.0v 31.78n 0.0v 31.82n 0.0v 35.779999999999994n 0.0v 35.82n 0.0v 39.779999999999994n 0.0v 39.82n 0.0v 43.779999999999994n 0.0v 43.82n 0.0v 47.779999999999994n 0.0v 47.82n 0.0v 51.779999999999994n 0.0v 51.82n 0.0v 55.779999999999994n 0.0v 55.82n 0.0v )
* (time, data): [(0, 0), (4.0, 0), (8.0, 0), (12.0, 0), (16.0, 0), (20.0, 0), (24.0, 0), (28.0, 0), (32.0, 0), (36.0, 0), (40.0, 0), (44.0, 0), (48.0, 0), (52.0, 0), (56.0, 0)]
Va1_2 a1_2 0 PWL (0n 0.0v 3.78n 0.0v 3.82n 0.0v 7.78n 0.0v 7.819999999999999n 0.0v 11.780000000000001n 0.0v 11.82n 0.0v 15.780000000000001n 0.0v 15.82n 0.0v 19.78n 0.0v 19.82n 0.0v 23.78n 0.0v 23.82n 0.0v 27.78n 0.0v 27.82n 0.0v 31.78n 0.0v 31.82n 0.0v 35.779999999999994n 0.0v 35.82n 0.0v 39.779999999999994n 0.0v 39.82n 0.0v 43.779999999999994n 0.0v 43.82n 0.0v 47.779999999999994n 0.0v 47.82n 0.0v 51.779999999999994n 0.0v 51.82n 0.0v 55.779999999999994n 0.0v 55.82n 0.0v )
* (time, data): [(0, 0), (4.0, 0), (8.0, 0), (12.0, 0), (16.0, 0), (20.0, 0), (24.0, 0), (28.0, 0), (32.0, 0), (36.0, 0), (40.0, 0), (44.0, 0), (48.0, 0), (52.0, 0), (56.0, 0)]
Va1_3 a1_3 0 PWL (0n 0.0v 3.78n 0.0v 3.82n 0.0v 7.78n 0.0v 7.819999999999999n 0.0v 11.780000000000001n 0.0v 11.82n 0.0v 15.780000000000001n 0.0v 15.82n 0.0v 19.78n 0.0v 19.82n 0.0v 23.78n 0.0v 23.82n 0.0v 27.78n 0.0v 27.82n 0.0v 31.78n 0.0v 31.82n 0.0v 35.779999999999994n 0.0v 35.82n 0.0v 39.779999999999994n 0.0v 39.82n 0.0v 43.779999999999994n 0.0v 43.82n 0.0v 47.779999999999994n 0.0v 47.82n 0.0v 51.779999999999994n 0.0v 51.82n 0.0v 55.779999999999994n 0.0v 55.82n 0.0v )
* (time, data): [(0, 0), (4.0, 0), (8.0, 0), (12.0, 0), (16.0, 0), (20.0, 0), (24.0, 0), (28.0, 0), (32.0, 0), (36.0, 0), (40.0, 0), (44.0, 0), (48.0, 0), (52.0, 0), (56.0, 0)]
Va1_4 a1_4 0 PWL (0n 0.0v 3.78n 0.0v 3.82n 0.0v 7.78n 0.0v 7.819999999999999n 0.0v 11.780000000000001n 0.0v 11.82n 0.0v 15.780000000000001n 0.0v 15.82n 0.0v 19.78n 0.0v 19.82n 0.0v 23.78n 0.0v 23.82n 0.0v 27.78n 0.0v 27.82n 0.0v 31.78n 0.0v 31.82n 0.0v 35.779999999999994n 0.0v 35.82n 0.0v 39.779999999999994n 0.0v 39.82n 0.0v 43.779999999999994n 0.0v 43.82n 0.0v 47.779999999999994n 0.0v 47.82n 0.0v 51.779999999999994n 0.0v 51.82n 0.0v 55.779999999999994n 0.0v 55.82n 0.0v )
* (time, data): [(0, 0), (4.0, 0), (8.0, 0), (12.0, 0), (16.0, 0), (20.0, 0), (24.0, 0), (28.0, 0), (32.0, 0), (36.0, 0), (40.0, 0), (44.0, 0), (48.0, 0), (52.0, 0), (56.0, 0)]
Va1_5 a1_5 0 PWL (0n 0.0v 3.78n 0.0v 3.82n 0.0v 7.78n 0.0v 7.819999999999999n 0.0v 11.780000000000001n 0.0v 11.82n 0.0v 15.780000000000001n 0.0v 15.82n 0.0v 19.78n 0.0v 19.82n 0.0v 23.78n 0.0v 23.82n 0.0v 27.78n 0.0v 27.82n 0.0v 31.78n 0.0v 31.82n 0.0v 35.779999999999994n 0.0v 35.82n 0.0v 39.779999999999994n 0.0v 39.82n 0.0v 43.779999999999994n 0.0v 43.82n 0.0v 47.779999999999994n 0.0v 47.82n 0.0v 51.779999999999994n 0.0v 51.82n 0.0v 55.779999999999994n 0.0v 55.82n 0.0v )
* (time, data): [(0, 0), (4.0, 0), (8.0, 0), (12.0, 0), (16.0, 0), (20.0, 0), (24.0, 0), (28.0, 0), (32.0, 0), (36.0, 0), (40.0, 0), (44.0, 0), (48.0, 0), (52.0, 0), (56.0, 0)]
Va1_6 a1_6 0 PWL (0n 0.0v 3.78n 0.0v 3.82n 0.0v 7.78n 0.0v 7.819999999999999n 0.0v 11.780000000000001n 0.0v 11.82n 0.0v 15.780000000000001n 0.0v 15.82n 0.0v 19.78n 0.0v 19.82n 0.0v 23.78n 0.0v 23.82n 0.0v 27.78n 0.0v 27.82n 0.0v 31.78n 0.0v 31.82n 0.0v 35.779999999999994n 0.0v 35.82n 0.0v 39.779999999999994n 0.0v 39.82n 0.0v 43.779999999999994n 0.0v 43.82n 0.0v 47.779999999999994n 0.0v 47.82n 0.0v 51.779999999999994n 0.0v 51.82n 0.0v 55.779999999999994n 0.0v 55.82n 0.0v )
* (time, data): [(0, 0), (4.0, 0), (8.0, 0), (12.0, 0), (16.0, 0), (20.0, 0), (24.0, 0), (28.0, 0), (32.0, 0), (36.0, 0), (40.0, 0), (44.0, 0), (48.0, 0), (52.0, 0), (56.0, 0)]
Va1_7 a1_7 0 PWL (0n 0.0v 3.78n 0.0v 3.82n 0.0v 7.78n 0.0v 7.819999999999999n 0.0v 11.780000000000001n 0.0v 11.82n 0.0v 15.780000000000001n 0.0v 15.82n 0.0v 19.78n 0.0v 19.82n 0.0v 23.78n 0.0v 23.82n 0.0v 27.78n 0.0v 27.82n 0.0v 31.78n 0.0v 31.82n 0.0v 35.779999999999994n 0.0v 35.82n 0.0v 39.779999999999994n 0.0v 39.82n 0.0v 43.779999999999994n 0.0v 43.82n 0.0v 47.779999999999994n 0.0v 47.82n 0.0v 51.779999999999994n 0.0v 51.82n 0.0v 55.779999999999994n 0.0v 55.82n 0.0v )

* Generation of control signals
* (time, data): [(0, 1), (4.0, 0), (8.0, 0), (12.0, 1), (16.0, 0), (20.0, 0), (24.0, 1), (28.0, 1), (32.0, 0), (36.0, 1), (40.0, 0), (44.0, 1), (48.0, 0), (52.0, 0), (56.0, 1)]
VCSB0 CSB0 0 PWL (0n 1.8v 3.78n 1.8v 3.82n 0.0v 7.78n 0.0v 7.819999999999999n 0.0v 11.780000000000001n 0.0v 11.82n 1.8v 15.780000000000001n 1.8v 15.82n 0.0v 19.78n 0.0v 19.82n 0.0v 23.78n 0.0v 23.82n 1.8v 27.78n 1.8v 27.82n 1.8v 31.78n 1.8v 31.82n 0.0v 35.779999999999994n 0.0v 35.82n 1.8v 39.779999999999994n 1.8v 39.82n 0.0v 43.779999999999994n 0.0v 43.82n 1.8v 47.779999999999994n 1.8v 47.82n 0.0v 51.779999999999994n 0.0v 51.82n 0.0v 55.779999999999994n 0.0v 55.82n 1.8v )
* (time, data): [(0, 1), (4.0, 0), (8.0, 0), (12.0, 1), (16.0, 1), (20.0, 1), (24.0, 1), (28.0, 1), (32.0, 0), (36.0, 1), (40.0, 0), (44.0, 1), (48.0, 1), (52.0, 1), (56.0, 1)]
VWEB0 WEB0 0 PWL (0n 1.8v 3.78n 1.8v 3.82n 0.0v 7.78n 0.0v 7.819999999999999n 0.0v 11.780000000000001n 0.0v 11.82n 1.8v 15.780000000000001n 1.8v 15.82n 1.8v 19.78n 1.8v 19.82n 1.8v 23.78n 1.8v 23.82n 1.8v 27.78n 1.8v 27.82n 1.8v 31.78n 1.8v 31.82n 0.0v 35.779999999999994n 0.0v 35.82n 1.8v 39.779999999999994n 1.8v 39.82n 0.0v 43.779999999999994n 0.0v 43.82n 1.8v 47.779999999999994n 1.8v 47.82n 1.8v 51.779999999999994n 1.8v 51.82n 1.8v 55.779999999999994n 1.8v 55.82n 1.8v )
* (time, data): [(0, 0), (4.0, 1), (8.0, 1), (12.0, 1), (16.0, 1), (20.0, 1), (24.0, 1), (28.0, 1), (32.0, 1), (36.0, 1), (40.0, 1), (44.0, 1), (48.0, 1), (52.0, 1), (56.0, 1)]
VWMASK0_0 WMASK0_0 0 PWL (0n 0.0v 3.78n 0.0v 3.82n 1.8v 7.78n 1.8v 7.819999999999999n 1.8v 11.780000000000001n 1.8v 11.82n 1.8v 15.780000000000001n 1.8v 15.82n 1.8v 19.78n 1.8v 19.82n 1.8v 23.78n 1.8v 23.82n 1.8v 27.78n 1.8v 27.82n 1.8v 31.78n 1.8v 31.82n 1.8v 35.779999999999994n 1.8v 35.82n 1.8v 39.779999999999994n 1.8v 39.82n 1.8v 43.779999999999994n 1.8v 43.82n 1.8v 47.779999999999994n 1.8v 47.82n 1.8v 51.779999999999994n 1.8v 51.82n 1.8v 55.779999999999994n 1.8v 55.82n 1.8v )
* (time, data): [(0, 0), (4.0, 1), (8.0, 1), (12.0, 1), (16.0, 1), (20.0, 1), (24.0, 1), (28.0, 1), (32.0, 1), (36.0, 1), (40.0, 1), (44.0, 1), (48.0, 1), (52.0, 1), (56.0, 1)]
VWMASK0_1 WMASK0_1 0 PWL (0n 0.0v 3.78n 0.0v 3.82n 1.8v 7.78n 1.8v 7.819999999999999n 1.8v 11.780000000000001n 1.8v 11.82n 1.8v 15.780000000000001n 1.8v 15.82n 1.8v 19.78n 1.8v 19.82n 1.8v 23.78n 1.8v 23.82n 1.8v 27.78n 1.8v 27.82n 1.8v 31.78n 1.8v 31.82n 1.8v 35.779999999999994n 1.8v 35.82n 1.8v 39.779999999999994n 1.8v 39.82n 1.8v 43.779999999999994n 1.8v 43.82n 1.8v 47.779999999999994n 1.8v 47.82n 1.8v 51.779999999999994n 1.8v 51.82n 1.8v 55.779999999999994n 1.8v 55.82n 1.8v )
* (time, data): [(0, 0), (4.0, 1), (8.0, 1), (12.0, 1), (16.0, 1), (20.0, 1), (24.0, 1), (28.0, 1), (32.0, 1), (36.0, 1), (40.0, 1), (44.0, 1), (48.0, 1), (52.0, 1), (56.0, 1)]
VWMASK0_2 WMASK0_2 0 PWL (0n 0.0v 3.78n 0.0v 3.82n 1.8v 7.78n 1.8v 7.819999999999999n 1.8v 11.780000000000001n 1.8v 11.82n 1.8v 15.780000000000001n 1.8v 15.82n 1.8v 19.78n 1.8v 19.82n 1.8v 23.78n 1.8v 23.82n 1.8v 27.78n 1.8v 27.82n 1.8v 31.78n 1.8v 31.82n 1.8v 35.779999999999994n 1.8v 35.82n 1.8v 39.779999999999994n 1.8v 39.82n 1.8v 43.779999999999994n 1.8v 43.82n 1.8v 47.779999999999994n 1.8v 47.82n 1.8v 51.779999999999994n 1.8v 51.82n 1.8v 55.779999999999994n 1.8v 55.82n 1.8v )
* (time, data): [(0, 0), (4.0, 1), (8.0, 1), (12.0, 1), (16.0, 1), (20.0, 1), (24.0, 1), (28.0, 1), (32.0, 1), (36.0, 1), (40.0, 1), (44.0, 1), (48.0, 1), (52.0, 1), (56.0, 1)]
VWMASK0_3 WMASK0_3 0 PWL (0n 0.0v 3.78n 0.0v 3.82n 1.8v 7.78n 1.8v 7.819999999999999n 1.8v 11.780000000000001n 1.8v 11.82n 1.8v 15.780000000000001n 1.8v 15.82n 1.8v 19.78n 1.8v 19.82n 1.8v 23.78n 1.8v 23.82n 1.8v 27.78n 1.8v 27.82n 1.8v 31.78n 1.8v 31.82n 1.8v 35.779999999999994n 1.8v 35.82n 1.8v 39.779999999999994n 1.8v 39.82n 1.8v 43.779999999999994n 1.8v 43.82n 1.8v 47.779999999999994n 1.8v 47.82n 1.8v 51.779999999999994n 1.8v 51.82n 1.8v 55.779999999999994n 1.8v 55.82n 1.8v )
* (time, data): [(0, 1), (4.0, 1), (8.0, 1), (12.0, 1), (16.0, 1), (20.0, 1), (24.0, 1), (28.0, 1), (32.0, 1), (36.0, 1), (40.0, 1), (44.0, 1), (48.0, 1), (52.0, 1), (56.0, 1)]
VCSB1 CSB1 0 PWL (0n 1.8v 3.78n 1.8v 3.82n 1.8v 7.78n 1.8v 7.819999999999999n 1.8v 11.780000000000001n 1.8v 11.82n 1.8v 15.780000000000001n 1.8v 15.82n 1.8v 19.78n 1.8v 19.82n 1.8v 23.78n 1.8v 23.82n 1.8v 27.78n 1.8v 27.82n 1.8v 31.78n 1.8v 31.82n 1.8v 35.779999999999994n 1.8v 35.82n 1.8v 39.779999999999994n 1.8v 39.82n 1.8v 43.779999999999994n 1.8v 43.82n 1.8v 47.779999999999994n 1.8v 47.82n 1.8v 51.779999999999994n 1.8v 51.82n 1.8v 55.779999999999994n 1.8v 55.82n 1.8v )

* Generation of Port clock signal
* PULSE: period=4.0
VCLK0 CLK0 0 PULSE (0 1.8 4.0n 0.04n 0.04n 1.96n 4.0n)
* PULSE: period=4.0
VCLK1 CLK1 0 PULSE (0 1.8 4.0n 0.04n 0.04n 1.96n 4.0n)
.include /home/luxyxp/Documents/mainfiles/asic/reports/sram_characterization/tests/pilot_4ns_internal_nodes/internal_nodes_meas.sp
* Measure statements for delay and power

.TEMP 25
.TRAN 20p 35.5n 0n 20p UIC
.OPTIONS POST=1 RELTOL=0.001 PROBE method=gear ACCT
* probe is used for hspice/xa, while plot is used in ngspice
*.probe V(*)
*.plot V(*)
.end
